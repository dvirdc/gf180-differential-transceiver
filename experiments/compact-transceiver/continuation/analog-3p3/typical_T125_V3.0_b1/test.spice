GF26e compact PHY loaded exact-RC loopback, typical_T125_V3.0_b1
.option seed=123
.include "/Users/dvirdc/Projects/gf180-phys/toolchain/pdk/gf180mcuD/libs.tech/ngspice/design.ngspice"
.lib "/Users/dvirdc/Projects/gf180-phys/toolchain/pdk/gf180mcuD/libs.tech/ngspice/sm141064.ngspice" typical
.lib "/Users/dvirdc/Projects/gf180-phys/toolchain/pdk/gf180mcuD/libs.tech/ngspice/sm141064.ngspice" res_typical
.param sw_stat_global=0 sw_stat_mismatch=0
.temp 125
.include "/Users/dvirdc/Projects/gf180-phys/gf180-differential-transceiver-compact/build/physical/phy/pex/phy_pex.spice"
.include "/Users/dvirdc/Projects/gf180-phys/gf180-differential-transceiver-compact/build/analog/access-switch/tt_asw_5v0.spice"
vdd vdd 0 3.0
vharness vh 0 3.3
vin din 0 PWL(0 3.0 19.99u 3.0 2e-05 3.0 2.001e-05 0.0 3e-05 0.0 3.001e-05 3.0 4e-05 3.0 4.001e-05 0.0 5e-05 0.0 5.001e-05 3.0 6e-05 3.0 6.001e-05 0.0 7e-05 0.0 7.001e-05 0.0 8e-05 0.0 8.001e-05 3.0 9e-05 3.0 9.001e-05 0.0 0.0001 0.0 0.00010001 3.0 0.00011 3.0 0.00011001 3.0 0.00012 3.0 0.00012001 0.0 0.00013 0.0 0.00013001 0.0 0.00014 0.0 0.00014001 3.0 0.00015 3.0 0.00015001 0.0 0.00016 0.0 0.00016001 3.0 0.00017 3.0 0.00017001 0.0 0.00018 0.0 0.00018001 0.0 0.00019 0.0 0.00019001 3.0 0.0002 3.0 0.00020001 0.0 0.00021 0.0 0.00021001 3.0 0.00022 3.0 0.00022001 0.0 0.00023 0.0 0.00023001 3.0 0.00024 3.0 0.00024001 0.0 0.00025 0.0 0.00025001 3.0 0.00026 3.0 0.00026001 0.0 0.00027 0.0 0.00027001 3.0 0.00028 3.0 0.00028001 0.0 0.00029 0.0 0.00029001 0.0 0.0003 0.0 0.00030001 3.0 0.00031 3.0 0.00031001 3.0 0.00032 3.0 0.00032001 0.0 0.00033 0.0 0.00033001 0.0 0.00034 0.0 0.00034001 3.0 0.00035 3.0 0.00035001 0.0 0.00036 0.0 0.00036001 3.0 0.00037 3.0 0.00037001 0.0 0.00038 0.0 0.00038001 3.0 0.00039 3.0 0.00039001 0.0 0.0004 0.0 0.00040001 0.0 0.00041 0.0 0.00041001 3.0 0.00042 3.0 0.00042001 0.0 0.00043 0.0 0.00043001 0.0 0.00044 0.0 0.00044001 0.0 0.00045 0.0 0.00045001 3.0 0.00046 3.0 0.00046001 0.0 0.00047 0.0 0.00047001 3.0 0.00048 3.0 0.00048001 0.0 0.00049 0.0 0.00049001 3.0 0.0005 3.0 0.00050001 0.0 0.00051 0.0 0.00051001 3.0 0.00052 3.0 0.00052001 0.0 0.00053 0.0 0.00053001 3.0 0.00054 3.0 0.00054001 0.0 0.00055 0.0 0.00055001 0.0 0.00056 0.0 0.00056001 3.0 0.00057 3.0 0.00057001 0.0 0.00058 0.0 0.00058001 3.0 0.00059 3.0 0.00059001 0.0 0.0006 0.0 0.00060001 3.0 0.00061 3.0 0.00061001 3.0 0.00062 3.0 0.00062001 0.0 0.00063 0.0 0.00063001 3.0 0.00064 3.0 0.00064001 3.0 0.00065 3.0 0.00065001 0.0 0.00066 0.0 0.00066001 0.0 0.00067 0.0 0.00067001 3.0 0.00068 3.0 0.00068001 0.0 0.00069 0.0 0.00069001 3.0 0.0007 3.0 0.00070001 0.0 0.00071 0.0 0.00071001 3.0 0.00072 3.0 0.00072001 0.0 0.00073 0.0 0.00073001 3.0 0.00074 3.0 0.00074001 3.0 0.00075 3.0 0.00075001 3.0 0.00076 3.0 0.00076001 0.0 0.00077 0.0 0.00077001 0.0 0.00078 0.0 0.00078001 3.0 0.00079 3.0 0.00079001 0.0 0.0008 0.0 0.00080001 3.0 0.00081 3.0 0.00081001 3.0 0.00082 3.0 0.00082001 0.0 0.00083 0.0 0.00083001 0.0 0.00084 0.0 0.00084001 3.0 0.00085 3.0 0.00085001 3.0 0.00086 3.0 0.00086001 3.0 0.00087 3.0 0.00087001 0.0 0.00088 0.0 0.00088001 0.0 0.00089 0.0 0.00089001 3.0 0.0009 3.0 0.00090001 0.0 0.00091 0.0 0.00091001 3.0 0.00092 3.0 0.00092001 0.0 0.00093 0.0 0.00093001 3.0 0.00094 3.0 0.00094001 0.0 0.00095 0.0 0.00095001 3.0 0.00096 3.0 0.00096001 3.0 0.00097 3.0 0.00097001 3.0 0.00098 3.0 0.00098001 0.0 0.00099 0.0 0.00099001 0.0 0.001 0.0 0.00100001 3.0 0.00101 3.0 0.00101001 3.0 0.00102 3.0 0.00102001 0.0 0.00103 0.0 0.00103001 3.0 0.00104 3.0 0.00104001 3.0 0.00105 3.0 0.00105001 0.0 0.00106 0.0 0.00106001 3.0 0.00107 3.0 0.00107001 3.0 0.00108 3.0 0.00108001 3.0 0.00109 3.0 0.00109001 0.0 0.0011 0.0 0.00110001 0.0 0.00111 0.0 0.00111001 3.0 0.00112 3.0 0.00112001 0.0 0.00113 0.0 0.00113001 3.0 0.00114 3.0 0.00114001 3.0 0.00115 3.0 0.00115001 3.0 0.00116 3.0 0.00116001 0.0 0.00117 0.0 0.00117001 3.0 0.00118 3.0 0.00118001 3.0 0.00119 3.0 0.00119001 3.0 0.0012 3.0 0.00120001 0.0 0.00121 0.0 0.00121001 3.0)
vboost boost 0 3.0
xphy din boost rp rn tp tn dout vdd 0 phy_pex
* Exact current-shuttle switch topology; explicit 3.3V analog switch supply assumption.
xsw_tp 0 vdd vh vdd tp pp tt_asw_5v0
xsw_tn 0 vdd vh vdd tn pn tt_asw_5v0
xsw_rp 0 vdd vh vdd rp pp tt_asw_5v0
xsw_rn 0 vdd vh vdd rn pn tt_asw_5v0
ccp rp 0 20p
ccn rn 0 20p
rload rp rn 1meg
cout dout 0 5p
.control
set wr_vecnames
set wr_singlescale
tran 50n 1.23m
wrdata wave.dat v(din) v(dout) v(tp) v(tn) i(vdd) i(vharness)
quit
.endc
.end
