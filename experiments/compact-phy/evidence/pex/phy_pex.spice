* NGSPICE file created from phy_pex.ext - technology: gf180mcuD

.subckt phy_pex din boost rxp rxn txp txn dout VDPWR VGND
X0 VDPWR.t4 din xrn.P.t1 VDPWR.t3 pfet_03v3 ad=6.55p pd=21.31u as=6.55p ps=21.31u w=10u l=0.28u
X1 VDPWR.t10 xp2.D.t3 xbuf_xp.G.t0 VDPWR.t9 pfet_03v3 ad=6.55p pd=21.31u as=6.55p ps=21.31u w=10u l=0.28u
X2 VGND.t1 xout_xp.G.t2 dout.t1 VGND.t6 nfet_03v3 ad=2.62p pd=9.31u as=2.62p ps=9.31u w=4u l=0.28u
X3 xrt.P VGND.t1 VGND.t2 ppolyf_u_1k r_width=1u r_length=20u
X4 xrp2.P boost xrp.P.t0 VGND.t9 nfet_03v3 ad=7.86p pd=25.31u as=7.86p ps=25.31u w=12u l=0.28u
X5 VGND.t1 din xrn.P.t2 VGND.t4 nfet_03v3 ad=2.62p pd=9.31u as=2.62p ps=9.31u w=4u l=0.28u
X6 xrp2.P xtn_xp.G.t2 xrp.P.t3 VDPWR.t17 pfet_03v3 ad=15.72p pd=49.31u as=15.72p ps=49.31u w=24u l=0.28u
X7 VDPWR.t12 xp2.G.t3 xp2.D.t1 VDPWR.t11 pfet_03v3 ad=5.28p pd=24.88u as=5.28p ps=24.88u w=12u l=1u
X8 VDPWR.t2 boost xtn_xp.G.t0 VDPWR.t1 pfet_03v3 ad=6.55p pd=21.31u as=6.55p ps=21.31u w=10u l=0.28u
X9 VDPWR.t8 xout_xp.G.t3 dout.t0 VDPWR.t7 pfet_03v3 ad=6.55p pd=21.31u as=6.55p ps=21.31u w=10u l=0.28u
X10 xrn2.P txn.t2 VGND.t19 ppolyf_u_1k r_width=1u r_length=32u
X11 VGND.t1 boost xtn_xp.G.t1 VGND.t3 nfet_03v3 ad=2.62p pd=9.31u as=2.62p ps=9.31u w=4u l=0.28u
X12 xrn.P.t0 txn.t0 VGND.t14 ppolyf_u_1k r_width=1u r_length=32u
X13 txp.t1 xrc2.P VGND.t15 ppolyf_u_1k r_width=1u r_length=1u
X14 VGND.t1 xrn.P.t4 xrp.P.t1 VGND.t8 nfet_03v3 ad=2.62p pd=9.31u as=2.62p ps=9.31u w=4u l=0.28u
X15 xrt.P rxn xp2.G.t0 VGND.t11 nfet_03v3 ad=10.56p pd=48.88u as=10.56p ps=48.88u w=24u l=1u
X16 VGND.t1 xbuf_xp.G.t2 xout_xp.G.t0 VGND.t5 nfet_03v3 ad=2.62p pd=9.31u as=2.62p ps=9.31u w=4u l=0.28u
X17 xrn2.P xtn_xp.G.t3 xrn.P.t3 VDPWR.t18 pfet_03v3 ad=15.72p pd=49.31u as=15.72p ps=49.31u w=24u l=0.28u
X18 VDPWR.t14 xp2.G.t1 xp2.G.t2 VDPWR.t13 pfet_03v3 ad=5.28p pd=24.88u as=5.28p ps=24.88u w=12u l=1u
X19 txn.t1 xrc2.P VGND.t16 ppolyf_u_1k r_width=1u r_length=1u
X20 VDPWR.t16 xrn.P.t5 xrp.P.t2 VDPWR.t15 pfet_03v3 ad=6.55p pd=21.31u as=6.55p ps=21.31u w=10u l=0.28u
X21 VGND.t1 xp2.D.t2 xbuf_xp.G.t1 VGND.t7 nfet_03v3 ad=2.62p pd=9.31u as=2.62p ps=9.31u w=4u l=0.28u
X22 VDPWR.t0 xrc2.P VGND.t17 ppolyf_u_1k r_width=1u r_length=20u
X23 VDPWR.t6 xbuf_xp.G.t3 xout_xp.G.t1 VDPWR.t5 pfet_03v3 ad=6.55p pd=21.31u as=6.55p ps=21.31u w=10u l=0.28u
X24 xrn2.P boost xrn.P.t0 VGND.t10 nfet_03v3 ad=7.86p pd=25.31u as=7.86p ps=25.31u w=12u l=0.28u
X25 xrc2.P VGND.t1 VGND.t0 ppolyf_u_1k r_width=1u r_length=20u
X26 xrp2.P txp.t2 VGND.t18 ppolyf_u_1k r_width=1u r_length=32u
X27 xrp.P.t0 txp.t0 VGND.t13 ppolyf_u_1k r_width=1u r_length=32u
X28 xrt.P rxp xp2.D.t0 VGND.t12 nfet_03v3 ad=10.56p pd=48.88u as=10.56p ps=48.88u w=24u l=1u
R0 xtn_xp.G.t0 xtn_xp.G.t1 14.0656
R1 xtn_xp.G.t3 xtn_xp.G.t1 396.255
R2 xtn_xp.G.t3 xtn_xp.G.t2 5438.14
R3 xtn_xp.G.t1 xtn_xp.G.t2 394.88
R4 xrp.P.t3 xrp.P.t0 12.0316
R5 xrp.P.t0 xrp.P.t1 26.5549
R6 xrp.P.t0 xrp.P.t2 23.6943
R7 xrp.P.t1 xrp.P.t2 54.6146
R8 xrn.P.n0 xrn.P.t2 14.2115
R9 xrn.P.n0 xrn.P.t1 12.7906
R10 xrn.P.t3 xrn.P.t0 12.4816
R11 xrn.P.t0 xrn.P.n0 8.4695
R12 xrn.P.t5 xrn.P.n0 210.736
R13 xrn.P.t5 xrn.P.t4 1163.26
R14 xrn.P.n0 xrn.P.t4 110.986
R15 xp2.G.t0 xp2.G.t2 11.7798
R16 xp2.G.t3 xp2.G.t2 132.673
R17 xp2.G.t3 xp2.G.t1 253.055
R18 xp2.G.t2 xp2.G.t1 130.226
R19 xp2.D.t0 xp2.D.t1 11.5548
R20 xp2.D.t3 xp2.D.t1 242.802
R21 xp2.D.t3 xp2.D.t2 802.215
R22 xp2.D.t1 xp2.D.t2 128.496
R23 xout_xp.G.t1 xout_xp.G.t0 12.0406
R24 xout_xp.G.t3 xout_xp.G.t0 232.84
R25 xout_xp.G.t3 xout_xp.G.t2 893.063
R26 xout_xp.G.t0 xout_xp.G.t2 123.52
R27 xbuf_xp.G.t0 xbuf_xp.G.t1 12.2656
R28 xbuf_xp.G.t3 xbuf_xp.G.t1 226.605
R29 xbuf_xp.G.t3 xbuf_xp.G.t2 953.958
R30 xbuf_xp.G.t1 xbuf_xp.G.t2 120.069
R31 txp txp.n0 39.3755
R32 txp.n0 txp.t0 19.1612
R33 txp.t2 txp.n0 25.4381
R34 txp.t2 txp.t1 265.913
R35 txp.n0 txp.t1 20.2096
R36 txn txn.n0 40.8755
R37 txn.n0 txn.t0 18.9362
R38 txn.t2 txn.n0 23.8274
R39 txn.t2 txn.t1 396.507
R40 txn.n0 txn.t1 19.3777
R41 dout.t0 dout 86.0104
R42 dout.t0 dout.t1 31.4316
R43 dout dout.t1 87.9042
R44 VGND.t10 VGND.t11 3126.58
R45 VGND.t13 VGND.t12 1890.91
R46 VGND.t3 VGND.t8 560.225
R47 VGND.t7 VGND.t3 560.225
R48 VGND.t5 VGND.t7 560.225
R49 VGND.t6 VGND.t5 560.225
R50 VGND.t9 VGND.t6 554.732
R51 VGND.t5 VGND.n7 188.251
R52 VGND.t3 VGND.t1 188.251
R53 VGND.t8 VGND.t4 126.346
R54 VGND.n8 VGND.t15 41.1223
R55 VGND.n5 VGND.t19 35.8499
R56 VGND.t4 VGND.t1 25.6057
R57 VGND VGND.t2 19.1235
R58 VGND.n2 VGND.n3 15.8153
R59 VGND.n4 VGND.n1 15.8265
R60 VGND.n1 VGND.n0 1.8005
R61 VGND.n2 VGND 1.2005
R62 VGND.n2 VGND.n1 1.2005
R63 VGND.t18 VGND.n3 251.363
R64 VGND.t0 VGND.n4 1100.46
R65 VGND.t0 VGND.n3 40.2392
R66 VGND.n4 VGND.n3 77.7064
R67 VGND.t17 VGND.n4 40.051
R68 VGND.n5 VGND.t2 87.6671
R69 VGND.n5 VGND 22.0676
R70 VGND.n7 VGND.t1 2.61647
R71 VGND.n7 VGND.t7 350.007
R72 VGND.t1 VGND.t7 410.384
R73 VGND.t16 VGND.n8 274.113
R74 VGND.n0 VGND.n6 2.69556
R75 VGND.n0 VGND.t13 235.649
R76 VGND.n6 VGND.t13 381.846
R77 VGND.n6 VGND.t10 144.525
R78 VGND.n7 VGND.t6 248.186
R79 VGND.t10 VGND.t9 1718.16
R80 VGND.n8 VGND.n0 17.4827
R81 VGND.n3 VGND.n5 624.626
R82 VGND.t18 VGND.n5 314.627
R83 VGND.t18 VGND.n2 77.8843
R84 VGND.n5 VGND.n2 134.561
R85 VGND.n0 VGND.t14 67.126
R86 VGND.t14 VGND.t13 1433.48
R87 VGND.n8 VGND.n1 138.815
R88 VGND.t16 VGND.n1 76.3058
R89 VGND.t13 VGND.n8 4109.62
R90 VGND.t13 VGND.t15 71176.3
R91 VGND.t14 VGND.n8 319.091
R92 VGND.t14 VGND.t15 5526.48
R93 VGND.n0 VGND.t15 700.433
R94 VGND.n1 VGND.t17 2204.93
R95 VGND.n8 VGND.n4 639.328
R96 VGND.n8 VGND.t17 9054.04
R97 VGND.n4 VGND.t16 321.298
R98 VGND.t17 VGND.t16 4550.15
R99 VGND.n6 VGND.t12 5902.42
R100 VGND.n6 VGND.t11 5902.42
R101 VGND.t12 VGND.t11 1027.77
R102 VGND.t9 VGND.n6 379.443
R103 VGND.t9 VGND.t13 2037.25
R104 VGND.t10 VGND.t13 31992.3
R105 VGND.t6 VGND.t10 54749
R106 VGND.t6 VGND.n6 818.875
R107 VGND.n7 VGND.t10 348.997
R108 VGND.n7 VGND.n6 5.22039
R109 VGND.n7 VGND.t9 360.705
R110 VDPWR.n1 VDPWR.t3 71.5294
R111 VDPWR.n6 VDPWR.t7 70.3294
R112 VDPWR.n5 VDPWR.t9 70.3294
R113 VDPWR.n1 VDPWR.t15 70.3294
R114 VDPWR.n8 VDPWR.t11 69.7997
R115 VDPWR.n7 VDPWR.t18 43.6383
R116 VDPWR.n1 VDPWR.n0 15.0005
R117 VDPWR.n0 VDPWR.t4 11.2906
R118 VDPWR.n3 VDPWR.t6 10.0906
R119 VDPWR.n4 VDPWR.t10 10.0906
R120 VDPWR.n0 VDPWR.t16 10.0906
R121 VDPWR.n2 VDPWR.t14 9.92267
R122 VDPWR VDPWR.n8 4.883
R123 VDPWR.n4 VDPWR.n3 1.2005
R124 VDPWR.n4 VDPWR.n0 2.54321
R125 VDPWR.n4 VDPWR.t2 21.3807
R126 VDPWR.n0 VDPWR.t2 21.3807
R127 VDPWR.t0 VDPWR.n2 25.157
R128 VDPWR.t0 VDPWR.t12 208.006
R129 VDPWR.n2 VDPWR.t12 11.6798
R130 VDPWR.n2 VDPWR.n3 5.93692
R131 VDPWR.n2 VDPWR.t8 49.9165
R132 VDPWR.n3 VDPWR.t8 14.151
R133 VDPWR.n5 VDPWR.n1 2.42098
R134 VDPWR.n5 VDPWR.t1 141.858
R135 VDPWR.n1 VDPWR.t1 141.858
R136 VDPWR.n6 VDPWR.n5 2.42098
R137 VDPWR.n6 VDPWR.t5 141.858
R138 VDPWR.n5 VDPWR.t5 141.858
R139 VDPWR.n7 VDPWR.n6 2.4335
R140 VDPWR.n7 VDPWR.t17 88.4762
R141 VDPWR.n6 VDPWR.t17 88.4762
R142 VDPWR.n8 VDPWR.n7 3.04213
R143 VDPWR.n8 VDPWR.t13 117.263
R144 VDPWR.n7 VDPWR.t13 176.919
C0 xtn_xp.G.t1 xrp.P.t0 0.60532f
C1 xtn_xp.G.t1 xrn.P.n0 0.64539f
C2 xtn_xp.G.t1 xp2.G.t2 0.34779f
C3 xtn_xp.G.t1 xp2.D.t1 0.34631f
C4 xtn_xp.G.t1 xout_xp.G.t0 0.34254f
C5 xtn_xp.G.t1 xbuf_xp.G.t1 0.42929f
C6 xtn_xp.G.t1 xrp2.P 0.64219f
C7 xtn_xp.G.t1 xrn2.P 0.67147f
C8 xtn_xp.G.t1 xrt.P 0.23611f
C9 xtn_xp.G.t1 xrc2.P 21.5506f
C10 xtn_xp.G.t1 VDPWR 5.30358f
C11 xtn_xp.G.t1 din 0.54417f
C12 xtn_xp.G.t1 boost 21.6969f
C13 xtn_xp.G.t1 dout 0.23371f
C14 xtn_xp.G.t1 rxn 0.29195f
C15 xtn_xp.G.t1 rxp 0.28872f
C16 xtn_xp.G.t1 txp 0.25546f
C17 xtn_xp.G.t1 txn 0.25364f
C18 xrp.P.t0 xrn.P.n0 0.70238f
C19 xrp.P.t0 xp2.G.t2 21.9425f
C20 xrp.P.t0 xp2.D.t1 0.60115f
C21 xrp.P.t0 xout_xp.G.t0 0.52135f
C22 xrp.P.t0 xbuf_xp.G.t1 0.55046f
C23 xrp.P.t0 xrp2.P 4.27006f
C24 xrp.P.t0 xrn2.P 0.27466f
C25 xrp.P.t0 xrt.P 0.44867f
C26 xrp.P.t0 xrc2.P 0.35348f
C27 xrp.P.t0 VDPWR 7.11313f
C28 xrp.P.t0 din 0.15312f
C29 xrp.P.t0 boost 0.23239f
C30 xrp.P.t0 dout 21.6722f
C31 xrp.P.t0 rxn 0.47283f
C32 xrp.P.t0 rxp 0.50922f
C33 xrp.P.t0 txp 1.0082f
C34 xrp.P.t0 txn 0.51261f
C35 xrn.P.n0 xp2.G.t2 0.56922f
C36 xrn.P.n0 xp2.D.t1 0.65565f
C37 xrn.P.n0 xout_xp.G.t0 0.54796f
C38 xrn.P.n0 xbuf_xp.G.t1 0.70543f
C39 xrn.P.n0 xrp2.P 0.6613f
C40 xrn.P.n0 xrn2.P 4.65721f
C41 xrn.P.n0 xrt.P 0.59767f
C42 xrn.P.n0 xrc2.P 0.50227f
C43 xrn.P.n0 VDPWR 8.76878f
C44 xrn.P.n0 din 21.7836f
C45 xrn.P.n0 boost 0.40608f
C46 xrn.P.n0 dout 21.7691f
C47 xrn.P.n0 rxn 0.48217f
C48 xrn.P.n0 rxp 0.49635f
C49 xrn.P.n0 txp 0.61669f
C50 xrn.P.n0 txn 1.1087f
C51 xp2.G.t2 xp2.D.t1 22.1091f
C52 xp2.G.t2 xout_xp.G.t0 0.34441f
C53 xp2.G.t2 xbuf_xp.G.t1 0.34979f
C54 xp2.G.t2 xrp2.P 0.37324f
C55 xp2.G.t2 xrn2.P 0.62377f
C56 xp2.G.t2 xrt.P 1.50405f
C57 xp2.G.t2 xrc2.P 0.46101f
C58 xp2.G.t2 VDPWR 7.36806f
C59 xp2.G.t2 din 0.21415f
C60 xp2.G.t2 boost 0.2121f
C61 xp2.G.t2 dout 0.34567f
C62 xp2.G.t2 rxn 0.91896f
C63 xp2.G.t2 rxp 0.34622f
C64 xp2.G.t2 txp 0.35935f
C65 xp2.G.t2 txn 0.36211f
C66 xp2.D.t1 xout_xp.G.t0 0.35324f
C67 xp2.D.t1 xbuf_xp.G.t1 21.8237f
C68 xp2.D.t1 xrp2.P 0.37138f
C69 xp2.D.t1 xrn2.P 0.40426f
C70 xp2.D.t1 xrt.P 1.48359f
C71 xp2.D.t1 xrc2.P 0.45742f
C72 xp2.D.t1 VDPWR 5.49119f
C73 xp2.D.t1 din 0.21233f
C74 xp2.D.t1 boost 0.21632f
C75 xp2.D.t1 dout 0.34043f
C76 xp2.D.t1 rxn 0.32086f
C77 xp2.D.t1 rxp 0.90812f
C78 xp2.D.t1 txp 0.46845f
C79 xp2.D.t1 txn 0.34f
C80 xout_xp.G.t0 xbuf_xp.G.t1 21.8939f
C81 xout_xp.G.t0 xrp2.P 0.37143f
C82 xout_xp.G.t0 xrn2.P 0.40378f
C83 xout_xp.G.t0 xrt.P 0.26734f
C84 xout_xp.G.t0 xrc2.P 0.39476f
C85 xout_xp.G.t0 VDPWR 5.61852f
C86 xout_xp.G.t0 din 0.21124f
C87 xout_xp.G.t0 boost 0.21099f
C88 xout_xp.G.t0 dout 0.57687f
C89 xout_xp.G.t0 rxn 21.5991f
C90 xout_xp.G.t0 rxp 0.30137f
C91 xout_xp.G.t0 txp 0.34131f
C92 xout_xp.G.t0 txn 0.34499f
C93 xbuf_xp.G.t1 xrp2.P 0.37105f
C94 xbuf_xp.G.t1 xrn2.P 0.40378f
C95 xbuf_xp.G.t1 xrt.P 0.26535f
C96 xbuf_xp.G.t1 xrc2.P 0.39904f
C97 xbuf_xp.G.t1 VDPWR 5.54863f
C98 xbuf_xp.G.t1 din 0.21142f
C99 xbuf_xp.G.t1 boost 0.21417f
C100 xbuf_xp.G.t1 dout 0.34258f
C101 xbuf_xp.G.t1 rxn 0.30183f
C102 xbuf_xp.G.t1 rxp 0.29756f
C103 xbuf_xp.G.t1 txp 0.34099f
C104 xbuf_xp.G.t1 txn 0.34429f
C105 xrp2.P xrn2.P 21.7655f
C106 xrp2.P xrt.P 0.26844f
C107 xrp2.P xrc2.P 0.38772f
C108 xrp2.P VDPWR 3.89224f
C109 xrp2.P din 0.43209f
C110 xrp2.P boost 21.936f
C111 xrp2.P dout 0.28941f
C112 xrp2.P rxn 0.31764f
C113 xrp2.P rxp 0.31771f
C114 xrp2.P txp 0.99752f
C115 xrp2.P txn 0.27036f
C116 xrn2.P xrt.P 0.33807f
C117 xrn2.P xrc2.P 0.29428f
C118 xrn2.P VDPWR 4.03412f
C119 xrn2.P din 0.45003f
C120 xrn2.P boost 0.70096f
C121 xrn2.P dout 0.26847f
C122 xrn2.P rxn 0.34118f
C123 xrn2.P rxp 0.33935f
C124 xrn2.P txp 0.50306f
C125 xrn2.P txn 0.95167f
C126 xrt.P xrc2.P 0.28379f
C127 xrt.P VDPWR 1.54548f
C128 xrt.P din 0.11445f
C129 xrt.P boost 0.124f
C130 xrt.P dout 0.22776f
C131 xrt.P rxn 0.71137f
C132 xrt.P rxp 22.0137f
C133 xrt.P txp 0.38275f
C134 xrt.P txn 21.7016f
C135 xrc2.P VDPWR 0.91735f
C136 xrc2.P din 21.8073f
C137 xrc2.P boost 0.11678f
C138 xrc2.P dout 0.35376f
C139 xrc2.P rxn 0.33961f
C140 xrc2.P rxp 0.33879f
C141 xrc2.P txp 0.58498f
C142 xrc2.P txn 0.86221f
C143 VDPWR din 2.25572f
C144 VDPWR boost 3.16692f
C145 VDPWR dout 3.25988f
C146 VDPWR rxn 1.3684f
C147 VDPWR rxp 1.22592f
C148 VDPWR txp 22.7834f
C149 VDPWR txn 1.60601f
C150 din boost 0.27204f
C151 din dout 0.29899f
C152 din rxn 0.1577f
C153 din rxp 0.15711f
C154 din txp 0.22873f
C155 din txn 0.23019f
C156 boost dout 0.10405f
C157 boost rxn 0.15769f
C158 boost rxp 0.17891f
C159 boost txp 0.15783f
C160 boost txn 0.11851f
C161 dout rxn 0.28262f
C162 dout rxp 0.28232f
C163 dout txp 0.3518f
C164 dout txn 0.34101f
C165 rxn rxp 21.4843f
C166 rxn txp 0.21687f
C167 rxn txn 0.22146f
C168 rxp txp 0.21842f
C169 rxp txn 0.22568f
C170 txp txn 21.6012f
C171 txn VGND 2.5105f
C172 txp VGND 2.46614f
C173 rxp VGND 6.43274f
C174 rxn VGND 6.16248f
C175 dout VGND 2.39466f
C176 boost VGND 9.91659f
C177 din VGND 7.3024f
C178 VDPWR VGND 1.155f
C179 xrc2.P VGND 9.27844f
C180 xrt.P VGND 11.1148f
C181 xrn2.P VGND 16.837f
C182 xrp2.P VGND 8.99389f
C183 VDPWR.n0 VGND 2.77322f
C184 VDPWR.n1 VGND 15.8448f
C185 VDPWR.t3 VGND 3.45105f
C186 VDPWR.t15 VGND 3.34929f
C187 VDPWR.t0 VGND 0.58615f
C188 VDPWR.t12 VGND 1.10676f
C189 VDPWR.t14 VGND 0.83626f
C190 VDPWR.n2 VGND 3.61467f
C191 VDPWR.t8 VGND 1.13987f
C192 VDPWR.t6 VGND 1.04144f
C193 VDPWR.n3 VGND 1.39177f
C194 VDPWR.t10 VGND 1.04144f
C195 VDPWR.n4 VGND 0.79611f
C196 VDPWR.t2 VGND 1.06903f
C197 VDPWR.t4 VGND 1.12549f
C198 VDPWR.t16 VGND 1.04144f
C199 VDPWR.t1 VGND 3.39786f
C200 VDPWR.t9 VGND 3.34929f
C201 VDPWR.n5 VGND 11.5057f
C202 VDPWR.t5 VGND 3.39826f
C203 VDPWR.t7 VGND 3.34929f
C204 VDPWR.n6 VGND 12.5734f
C205 VDPWR.t17 VGND 8.59382f
C206 VDPWR.t18 VGND 8.48619f
C207 VDPWR.n7 VGND 14.0892f
C208 VDPWR.t13 VGND 3.49058f
C209 VDPWR.t11 VGND 3.43561f
C210 VDPWR.n8 VGND 9.17298f
C211 dout.t0 VGND 1.76229f
C212 dout.t1 VGND 1.48481f
C213 txn.t2 VGND 0.16198f
C214 txn.t1 VGND 0.08639f
C215 txn.t0 VGND 0.07643f
C216 txn.n0 VGND 3.21091f
C217 txp.t2 VGND 0.2001f
C218 txp.t1 VGND 0.11168f
C219 txp.t0 VGND 0.08189f
C220 txp.n0 VGND 3.26918f
C221 xbuf_xp.G.t3 VGND 0.54461f
C222 xbuf_xp.G.t2 VGND 0.85994f
C223 xbuf_xp.G.t1 VGND 7.05596f
C224 xbuf_xp.G.t0 VGND 0.61214f
C225 xout_xp.G.t3 VGND 0.59116f
C226 xout_xp.G.t2 VGND 0.94365f
C227 xout_xp.G.t0 VGND 7.16731f
C228 xout_xp.G.t1 VGND 0.61163f
C229 xp2.D.t3 VGND 0.75492f
C230 xp2.D.t2 VGND 1.23529f
C231 xp2.D.t1 VGND 7.8481f
C232 xp2.D.t0 VGND 0.8475f
C233 xp2.G.t3 VGND 1.43531f
C234 xp2.G.t1 VGND 1.42915f
C235 xp2.G.t2 VGND 5.68937f
C236 xp2.G.t0 VGND 0.68368f
C237 xrn.P.t0 VGND 4.1107f
C238 xrn.P.n0 VGND 5.55125f
C239 xrn.P.t2 VGND 0.31859f
C240 xrn.P.t5 VGND 0.51656f
C241 xrn.P.t4 VGND 0.78515f
C242 xrn.P.t1 VGND 0.60592f
C243 xrn.P.t3 VGND 1.28614f
C244 xrp.P.t0 VGND 5.41421f
C245 xrp.P.t1 VGND 1.37767f
C246 xrp.P.t2 VGND 1.55816f
C247 xrp.P.t3 VGND 0.99667f
C248 xtn_xp.G.t3 VGND 0.3805f
C249 xtn_xp.G.t2 VGND 0.37628f
C250 xtn_xp.G.t1 VGND 5.95832f
C251 xtn_xp.G.t0 VGND 0.532f
.ends
