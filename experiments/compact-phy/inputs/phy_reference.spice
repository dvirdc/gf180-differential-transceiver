* GF180 3.3V short-wire differential PHY. Ports are internal ua nodes.
.subckt inv a y VDPWR VGND
xn y a VGND VGND nfet_03v3 w=4u l=0.28u
xp y a VDPWR VDPWR pfet_03v3 w=10u l=0.28u
.ends
.subckt tg a b en enb VDPWR VGND
xn a en b VGND nfet_03v3 w=12u l=0.28u
xp a enb b VDPWR pfet_03v3 w=24u l=0.28u
.ends
.subckt gf180_diff_phy din boost rxp rxn txp txn dout VDPWR VGND
xi0 din dinb VDPWR VGND inv
xi1 dinb dp VDPWR VGND inv
xib boost boostb VDPWR VGND inv
* PDK poly resistors, approx 32k drive / 1k shunt => 100mV differential.
xrp dp txp VGND ppolyf_u_1k r_length=32u r_width=1u
xrn dinb txn VGND ppolyf_u_1k r_length=32u r_width=1u
xrbp txp cm VGND ppolyf_u_1k r_length=1u r_width=1u
xrbn txn cm VGND ppolyf_u_1k r_length=1u r_width=1u
xrc1 VDPWR cm VGND ppolyf_u_1k r_length=20u r_width=1u
xrc2 cm VGND VGND ppolyf_u_1k r_length=20u r_width=1u
* Second drive leg approximately doubles differential swing when boost=1.
xtp dp ap boost boostb VDPWR VGND tg
xtn dinb an boost boostb VDPWR VGND tg
xrp2 ap txp VGND ppolyf_u_1k r_length=32u r_width=1u
xrn2 an txn VGND ppolyf_u_1k r_length=32u r_width=1u
* NMOS differential preamp with PMOS current mirror and resistive tail.
xn1 n1 rxn tail VGND nfet_03v3 w=24u l=1u
xn2 pre rxp tail VGND nfet_03v3 w=24u l=1u
xp1 n1 n1 VDPWR VDPWR pfet_03v3 w=12u l=1u
xp2 pre n1 VDPWR VDPWR pfet_03v3 w=12u l=1u
xrt tail VGND VGND ppolyf_u_1k r_length=20u r_width=1u
xis pre q VDPWR VGND inv
xbuf q qb VDPWR VGND inv
xout qb dout VDPWR VGND inv
.ends gf180_diff_phy
