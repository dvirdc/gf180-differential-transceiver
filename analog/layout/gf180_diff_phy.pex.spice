* NGSPICE file created from phy_pex.ext - technology: gf180mcuD

.subckt phy_pex din boost rxp rxn txp txn dout VDPWR VGND
X0 txn.t1 xrc2.P VGND.t16 ppolyf_u_1k r_width=1u r_length=1u
X1 txp.t1 xrc2.P VGND.t15 ppolyf_u_1k r_width=1u r_length=1u
X2 VDPWR.t2 boost.t1 xtn_xp.G.t1 VDPWR.t1 pfet_03v3 ad=6.55p pd=21.31u as=6.55p ps=21.31u w=10u l=0.28u
X3 xrn2.P.t2 xtn_xp.G.t3 xrn.P.t4 VDPWR.t18 pfet_03v3 ad=15.72p pd=49.31u as=15.72p ps=49.31u w=24u l=0.28u
X4 VDPWR.t16 xrn.P.t6 xrp.P.t3 VDPWR.t15 pfet_03v3 ad=6.55p pd=21.31u as=6.55p ps=21.31u w=10u l=0.28u
X5 VDPWR.t8 xout_xp.G.t3 dout.t0 VDPWR.t7 pfet_03v3 ad=6.55p pd=21.31u as=6.55p ps=21.31u w=10u l=0.28u
X6 xrn.P.t0 txn.t0 VGND.t14 ppolyf_u_1k r_width=1u r_length=32u
X7 xrc2.P VGND.t1 VGND.t0 ppolyf_u_1k r_width=1u r_length=20u
X8 xrp2.P.t2 xtn_xp.G.t2 xrp.P.t4 VDPWR.t17 pfet_03v3 ad=15.72p pd=49.31u as=15.72p ps=49.31u w=24u l=0.28u
X9 xrp.P.t0 txp.t0 VGND.t13 ppolyf_u_1k r_width=1u r_length=32u
X10 VDPWR.t0 xrc2.P VGND.t17 ppolyf_u_1k r_width=1u r_length=20u
X11 VDPWR.t4 din.t1 xrn.P.t3 VDPWR.t3 pfet_03v3 ad=6.55p pd=21.31u as=6.55p ps=21.31u w=10u l=0.28u
X12 VDPWR.t6 xbuf_xp.G.t3 xout_xp.G.t1 VDPWR.t5 pfet_03v3 ad=6.55p pd=21.31u as=6.55p ps=21.31u w=10u l=0.28u
X13 xrt.P.t2 rxp.t0 xp2.D.t0 VGND.t12 nfet_03v3 ad=10.56p pd=48.88u as=10.56p ps=48.88u w=24u l=1u
X14 VGND.t1 xp2.D.t2 xbuf_xp.G.t1 VGND.t7 nfet_03v3 ad=2.62p pd=9.31u as=2.62p ps=9.31u w=4u l=0.28u
X15 xrn2.P.t1 boost.t3 xrn.P.t1 VGND.t10 nfet_03v3 ad=7.86p pd=25.31u as=7.86p ps=25.31u w=12u l=0.28u
X16 VGND.t1 boost.t0 xtn_xp.G.t0 VGND.t3 nfet_03v3 ad=2.62p pd=9.31u as=2.62p ps=9.31u w=4u l=0.28u
X17 xrt.P.t1 rxn.t0 xp2.G.t0 VGND.t11 nfet_03v3 ad=10.56p pd=48.88u as=10.56p ps=48.88u w=24u l=1u
X18 VDPWR.t12 xp2.G.t3 xp2.D.t1 VDPWR.t11 pfet_03v3 ad=5.28p pd=24.88u as=5.28p ps=24.88u w=12u l=1u
X19 VGND.t1 xrn.P.t5 xrp.P.t2 VGND.t8 nfet_03v3 ad=2.62p pd=9.31u as=2.62p ps=9.31u w=4u l=0.28u
X20 VGND.t1 xout_xp.G.t2 dout.t1 VGND.t6 nfet_03v3 ad=2.62p pd=9.31u as=2.62p ps=9.31u w=4u l=0.28u
X21 VGND.t1 din.t0 xrn.P.t2 VGND.t4 nfet_03v3 ad=2.62p pd=9.31u as=2.62p ps=9.31u w=4u l=0.28u
X22 VGND.t1 xbuf_xp.G.t2 xout_xp.G.t0 VGND.t5 nfet_03v3 ad=2.62p pd=9.31u as=2.62p ps=9.31u w=4u l=0.28u
X23 xrn2.P.t0 txn.t2 VGND.t19 ppolyf_u_1k r_width=1u r_length=32u
X24 xrp2.P.t1 boost.t2 xrp.P.t1 VGND.t9 nfet_03v3 ad=7.86p pd=25.31u as=7.86p ps=25.31u w=12u l=0.28u
X25 VDPWR.t14 xp2.G.t1 xp2.G.t2 VDPWR.t13 pfet_03v3 ad=5.28p pd=24.88u as=5.28p ps=24.88u w=12u l=1u
X26 VDPWR.t10 xp2.D.t3 xbuf_xp.G.t0 VDPWR.t9 pfet_03v3 ad=6.55p pd=21.31u as=6.55p ps=21.31u w=10u l=0.28u
X27 xrp2.P.t0 txp.t2 VGND.t18 ppolyf_u_1k r_width=1u r_length=32u
X28 xrt.P.t0 VGND.t1 VGND.t2 ppolyf_u_1k r_width=1u r_length=20u
R0 xtn_xp.G.n0 xtn_xp.G.t0 19.868
R1 xtn_xp.G.t1 xtn_xp.G.n0 19.7281
R2 xtn_xp.G.t3 xtn_xp.G.n0 416.154
R3 xtn_xp.G.t3 xtn_xp.G.t2 4201.33
R4 xtn_xp.G.n0 xtn_xp.G.t2 414.358
R5 xrt.P.t0 xrt.P.t1 85.0826
R6 xrt.P.t0 xrt.P.t2 81.2596
R7 xrt.P.t1 xrt.P.t2 40.5988
R8 xrp2.P.t0 xrp2.P.t1 101.046
R9 xrp2.P.t0 xrp2.P.t2 96.0555
R10 xrp2.P.t1 xrp2.P.t2 48.9799
R11 xrp.P.n0 xrp.P.t0 33.5298
R12 xrp.P.n0 xrp.P.t1 17.7875
R13 xrp.P.t4 xrp.P.n0 17.5441
R14 xrp.P.n0 xrp.P.t2 35.1819
R15 xrp.P.n0 xrp.P.t3 32.2222
R16 xrp.P.t2 xrp.P.t3 83.7446
R17 xrn2.P.t0 xrn2.P.t1 100.171
R18 xrn2.P.t0 xrn2.P.t2 95.2777
R19 xrn2.P.t1 xrn2.P.t2 49.7895
R20 xrn.P.n1 xrn.P.t0 33.2298
R21 xrn.P.n0 xrn.P.t2 19.193
R22 xrn.P.n0 xrn.P.t3 18.3031
R23 xrn.P.n1 xrn.P.t1 18.2375
R24 xrn.P.t4 xrn.P.n1 17.9941
R25 xrn.P.n1 xrn.P.n0 11.2505
R26 xrn.P.t6 xrn.P.n0 230.344
R27 xrn.P.t6 xrn.P.t5 918.265
R28 xrn.P.n0 xrn.P.t5 122.013
R29 xp2.G.n0 xp2.G.t2 18.9602
R30 xp2.G.t0 xp2.G.n0 17.2923
R31 xp2.G.t3 xp2.G.n0 156.751
R32 xp2.G.t3 xp2.G.t1 225.861
R33 xp2.G.n0 xp2.G.t1 154.965
R34 xp2.D.n0 xp2.D.t1 18.7352
R35 xp2.D.t0 xp2.D.n0 17.0673
R36 xp2.D.t3 xp2.D.n0 272.839
R37 xp2.D.t3 xp2.D.t2 663.384
R38 xp2.D.n0 xp2.D.t2 145.213
R39 xout_xp.G.n0 xout_xp.G.t0 17.843
R40 xout_xp.G.t1 xout_xp.G.n0 17.7031
R41 xout_xp.G.t3 xout_xp.G.n0 260.717
R42 xout_xp.G.t3 xout_xp.G.t2 722.217
R43 xout_xp.G.n0 xout_xp.G.t2 139.089
R44 xbuf_xp.G.n0 xbuf_xp.G.t1 18.068
R45 xbuf_xp.G.t0 xbuf_xp.G.n0 17.9281
R46 xbuf_xp.G.t3 xbuf_xp.G.n0 252.797
R47 xbuf_xp.G.t3 xbuf_xp.G.t2 762.191
R48 xbuf_xp.G.n0 xbuf_xp.G.t2 134.704
R49 txp txp.n0 53.7755
R50 txp.n0 txp.t0 18.8552
R51 txp.t2 txp.n0 24.6604
R52 txp.t2 txp.t1 415.762
R53 txp.n0 txp.t1 25.5076
R54 txn txn.n0 54.8255
R55 txn.n0 txn.t0 19.0803
R56 txn.t2 txn.n0 24.8858
R57 txn.t2 txn.t1 423.711
R58 txn.n0 txn.t1 25.7322
R59 rxp rxp.t0 117.234
R60 rxn rxn.t0 117.758
R61 dout.t0 dout 116.704
R62 dout.t0 dout.t1 45.066
R63 dout dout.t1 117.57
R64 din din.t0 120.267
R65 din din.t1 224.382
R66 din.t0 din.t1 968.528
R67 boost.n0 boost.t2 190.663
R68 boost boost.t3 10.8005
R69 boost.t3 boost.n0 1.5005
R70 boost.n0 boost.t0 96.082
R71 boost.n0 boost.t1 179.898
R72 boost.t0 boost.t1 3016.35
R73 VGND.t3 VGND.t8 425.337
R74 VGND.t7 VGND.t3 425.337
R75 VGND.t5 VGND.t7 425.337
R76 VGND.t5 VGND.t6 422.86
R77 VGND.t9 VGND.t6 425.337
R78 VGND.t7 VGND.n8 189.489
R79 VGND.t9 VGND.n9 189.474
R80 VGND.n10 VGND.n7 71.3015
R81 VGND.n7 VGND.t13 23.2933
R82 VGND.n6 VGND.t14 23.2933
R83 VGND.n12 VGND.t15 27.5528
R84 VGND.n5 VGND.t19 23.2933
R85 VGND VGND.t2 20.4286
R86 VGND.n2 VGND.n3 17.3061
R87 VGND.n4 VGND.n1 17.3227
R88 VGND.n2 VGND 1.5005
R89 VGND.n2 VGND.n1 1.5005
R90 VGND.n1 VGND.n0 1.5005
R91 VGND.t18 VGND.n3 212.457
R92 VGND.t0 VGND.n4 896.696
R93 VGND.t0 VGND.n3 27.0065
R94 VGND.n4 VGND.n3 95.1895
R95 VGND.t17 VGND.n4 26.9251
R96 VGND.n8 VGND.t1 3.3722
R97 VGND.n8 VGND.t3 344.05
R98 VGND.t1 VGND.t3 425.933
R99 VGND.t4 VGND.t8 1105.99
R100 VGND.t4 VGND.t1 20.8126
R101 VGND.t8 VGND.t1 189.494
R102 VGND.n5 VGND.t2 102.447
R103 VGND.n5 VGND 23.1111
R104 VGND.n6 VGND.n0 22.1825
R105 VGND.n7 VGND.n6 103.043
R106 VGND.t16 VGND.n12 230.055
R107 VGND.n11 VGND.n9 3.40697
R108 VGND.n11 VGND.t10 231.486
R109 VGND.n9 VGND.t10 184.812
R110 VGND.t12 VGND.n10 1000.63
R111 VGND.n8 VGND.t5 286.106
R112 VGND.t9 VGND.t10 3374.52
R113 VGND.t9 VGND.n10 851.472
R114 VGND.t10 VGND.n10 11241.1
R115 VGND.t9 VGND.t11 567.894
R116 VGND.t10 VGND.t11 7949.33
R117 VGND.t12 VGND.t11 447.365
R118 VGND.n12 VGND.n0 20.7217
R119 VGND.n3 VGND.n5 946.707
R120 VGND.t18 VGND.n5 260.281
R121 VGND.t18 VGND.n2 57.9283
R122 VGND.n5 VGND.n2 177.054
R123 VGND.t5 VGND.n9 574.479
R124 VGND.n8 VGND.n9 4.54809
R125 VGND.n8 VGND.t6 574.479
R126 VGND.n9 VGND.t6 286.106
R127 VGND.t11 VGND.n11 4226.1
R128 VGND.n10 VGND.n11 4940.23
R129 VGND.t12 VGND.n11 4108.45
R130 VGND.n6 VGND.n11 1610
R131 VGND.n7 VGND.n0 37.9491
R132 VGND.n7 VGND.n11 65.9758
R133 VGND.n0 VGND.n11 4.28459
R134 VGND.n12 VGND.n6 122.046
R135 VGND.n0 VGND.t15 649.067
R136 VGND.n6 VGND.t15 1410.94
R137 VGND.n12 VGND.n1 186.956
R138 VGND.t16 VGND.n1 56.8123
R139 VGND.n1 VGND.t17 2008.35
R140 VGND.n12 VGND.n4 992.505
R141 VGND.n12 VGND.t17 9349.55
R142 VGND.n4 VGND.t16 274.661
R143 VGND.t17 VGND.t16 2587.35
R144 VDPWR.n7 VDPWR.t7 71.5669
R145 VDPWR.n6 VDPWR.t9 71.5669
R146 VDPWR.n5 VDPWR.t15 71.5669
R147 VDPWR.n0 VDPWR.t11 71.0372
R148 VDPWR.n0 VDPWR.t13 71.0372
R149 VDPWR.n8 VDPWR.t18 44.8758
R150 VDPWR.n1 VDPWR.t0 28.2347
R151 VDPWR.n4 VDPWR.t4 15.9721
R152 VDPWR.n2 VDPWR.t6 15.6031
R153 VDPWR.n3 VDPWR.t2 15.6031
R154 VDPWR.n1 VDPWR.t12 15.4352
R155 VDPWR.n1 VDPWR.t14 15.4352
R156 VDPWR VDPWR.n0 6.833
R157 VDPWR.n0 VDPWR.n8 3.011
R158 VDPWR.n1 VDPWR.n2 8.1135
R159 VDPWR.n1 VDPWR.t8 84.3899
R160 VDPWR.n2 VDPWR.t8 20.9824
R161 VDPWR.n2 VDPWR.n3 3.14471
R162 VDPWR.n2 VDPWR.t10 32.7057
R163 VDPWR.n3 VDPWR.t10 32.7057
R164 VDPWR.n3 VDPWR.n4 2.74023
R165 VDPWR.n3 VDPWR.t16 37.7962
R166 VDPWR.n4 VDPWR.t16 28.4985
R167 VDPWR.n5 VDPWR.t3 77.6958
R168 VDPWR.n5 VDPWR.n4 21.0988
R169 VDPWR.t3 VDPWR.n4 1205.3
R170 VDPWR.n6 VDPWR.n5 3.03194
R171 VDPWR.n6 VDPWR.t1 144.633
R172 VDPWR.n5 VDPWR.t1 144.633
R173 VDPWR.n7 VDPWR.n6 3.03194
R174 VDPWR.n7 VDPWR.t5 144.633
R175 VDPWR.n6 VDPWR.t5 144.633
R176 VDPWR.n8 VDPWR.n7 3.05064
R177 VDPWR.n8 VDPWR.t17 91.2512
R178 VDPWR.n7 VDPWR.t17 91.2512
C0 xtn_xp.G.n0 xrt.P.t1 0.2298f
C1 xtn_xp.G.n0 xrp2.P.t2 0.64704f
C2 xtn_xp.G.n0 xrp.P.n0 0.56107f
C3 xtn_xp.G.n0 xrn2.P.t2 0.67608f
C4 xtn_xp.G.n0 xrn.P.n0 0.59646f
C5 xtn_xp.G.n0 xp2.G.n0 0.34403f
C6 xtn_xp.G.n0 xp2.D.n0 0.34302f
C7 xtn_xp.G.n0 xout_xp.G.n0 0.34089f
C8 xtn_xp.G.n0 xbuf_xp.G.n0 0.40855f
C9 xtn_xp.G.n0 xrc2.P 29.1447f
C10 xtn_xp.G.n0 VDPWR 7.06161f
C11 xtn_xp.G.n0 din 0.36275f
C12 xtn_xp.G.n0 boost 29.2911f
C13 xtn_xp.G.n0 dout 0.23447f
C14 xtn_xp.G.n0 rxn 0.28812f
C15 xtn_xp.G.n0 rxp 0.28573f
C16 xtn_xp.G.n0 txp 0.22977f
C17 xtn_xp.G.n0 txn 0.22977f
C18 xrt.P.t1 xrp2.P.t2 0.27236f
C19 xrt.P.t1 xrp.P.n0 0.40347f
C20 xrt.P.t1 xrn2.P.t2 0.45236f
C21 xrt.P.t1 xrn.P.n0 0.62292f
C22 xrt.P.t1 xp2.G.n0 2.54031f
C23 xrt.P.t1 xp2.D.n0 2.54177f
C24 xrt.P.t1 xout_xp.G.n0 0.23491f
C25 xrt.P.t1 xbuf_xp.G.n0 0.23264f
C26 xrt.P.t1 xrc2.P 0.35691f
C27 xrt.P.t1 VDPWR 1.22897f
C28 xrt.P.t1 din 0.35494f
C29 xrt.P.t1 boost 0.1017f
C30 xrt.P.t1 dout 0.23027f
C31 xrt.P.t1 rxn 0.74034f
C32 xrt.P.t1 rxp 29.636f
C33 xrt.P.t1 txp 0.28703f
C34 xrt.P.t1 txn 29.3368f
C35 xrp2.P.t2 xrp.P.n0 6.88958f
C36 xrp2.P.t2 xrn2.P.t2 29.5714f
C37 xrp2.P.t2 xrn.P.n0 0.89443f
C38 xrp2.P.t2 xp2.G.n0 0.38472f
C39 xrp2.P.t2 xp2.D.n0 0.38348f
C40 xrp2.P.t2 xout_xp.G.n0 0.38373f
C41 xrp2.P.t2 xbuf_xp.G.n0 0.38348f
C42 xrp2.P.t2 xrc2.P 0.54862f
C43 xrp2.P.t2 VDPWR 3.83279f
C44 xrp2.P.t2 din 0.40941f
C45 xrp2.P.t2 boost 29.5371f
C46 xrp2.P.t2 dout 0.30229f
C47 xrp2.P.t2 rxn 0.32839f
C48 xrp2.P.t2 rxp 0.32832f
C49 xrp2.P.t2 txp 0.91813f
C50 xrp2.P.t2 txn 0.27236f
C51 xrp.P.n0 xrn2.P.t2 0.28346f
C52 xrp.P.n0 xrn.P.n0 1.01198f
C53 xrp.P.n0 xp2.G.n0 29.4145f
C54 xrp.P.n0 xp2.D.n0 0.59327f
C55 xrp.P.n0 xout_xp.G.n0 0.51491f
C56 xrp.P.n0 xbuf_xp.G.n0 0.51591f
C57 xrp.P.n0 xrc2.P 0.35978f
C58 xrp.P.n0 VDPWR 8.61533f
C59 xrp.P.n0 din 0.16449f
C60 xrp.P.n0 boost 0.2312f
C61 xrp.P.n0 dout 29.2358f
C62 xrp.P.n0 rxn 0.45838f
C63 xrp.P.n0 rxp 0.45812f
C64 xrp.P.n0 txp 1.09857f
C65 xrp.P.n0 txn 0.43476f
C66 xrn2.P.t2 xrn.P.n0 7.25445f
C67 xrn2.P.t2 xp2.G.n0 0.89488f
C68 xrn2.P.t2 xp2.D.n0 0.41747f
C69 xrn2.P.t2 xout_xp.G.n0 0.41747f
C70 xrn2.P.t2 xbuf_xp.G.n0 0.41747f
C71 xrn2.P.t2 xrc2.P 0.30607f
C72 xrn2.P.t2 VDPWR 3.9698f
C73 xrn2.P.t2 din 0.44313f
C74 xrn2.P.t2 boost 0.70916f
C75 xrn2.P.t2 dout 0.28344f
C76 xrn2.P.t2 rxn 0.34972f
C77 xrn2.P.t2 rxp 0.34953f
C78 xrn2.P.t2 txp 0.41272f
C79 xrn2.P.t2 txn 0.97806f
C80 xrn.P.n0 xp2.G.n0 0.74989f
C81 xrn.P.n0 xp2.D.n0 0.73189f
C82 xrn.P.n0 xout_xp.G.n0 0.57469f
C83 xrn.P.n0 xbuf_xp.G.n0 0.55873f
C84 xrn.P.n0 xrc2.P 0.57846f
C85 xrn.P.n0 VDPWR 9.45115f
C86 xrn.P.n0 din 29.3473f
C87 xrn.P.n0 boost 0.35549f
C88 xrn.P.n0 dout 29.3688f
C89 xrn.P.n0 rxn 0.54092f
C90 xrn.P.n0 rxp 0.69259f
C91 xrn.P.n0 txp 0.73677f
C92 xrn.P.n0 txn 1.10256f
C93 xp2.G.n0 xp2.D.n0 29.7402f
C94 xp2.G.n0 xout_xp.G.n0 0.3445f
C95 xp2.G.n0 xbuf_xp.G.n0 0.35004f
C96 xp2.G.n0 xrc2.P 0.47004f
C97 xp2.G.n0 VDPWR 8.70665f
C98 xp2.G.n0 din 0.29408f
C99 xp2.G.n0 boost 0.21463f
C100 xp2.G.n0 dout 0.35044f
C101 xp2.G.n0 rxn 0.91528f
C102 xp2.G.n0 rxp 0.2862f
C103 xp2.G.n0 txp 0.22172f
C104 xp2.G.n0 txn 0.222f
C105 xp2.D.n0 xout_xp.G.n0 0.35134f
C106 xp2.D.n0 xbuf_xp.G.n0 29.4119f
C107 xp2.D.n0 xrc2.P 0.46887f
C108 xp2.D.n0 VDPWR 6.63969f
C109 xp2.D.n0 din 0.47775f
C110 xp2.D.n0 boost 0.21369f
C111 xp2.D.n0 dout 0.34542f
C112 xp2.D.n0 rxn 0.28953f
C113 xp2.D.n0 rxp 0.9163f
C114 xp2.D.n0 txp 0.2232f
C115 xp2.D.n0 txn 0.22344f
C116 xout_xp.G.n0 xbuf_xp.G.n0 29.4693f
C117 xout_xp.G.n0 xrc2.P 0.46847f
C118 xout_xp.G.n0 VDPWR 7.01303f
C119 xout_xp.G.n0 din 0.24767f
C120 xout_xp.G.n0 boost 0.21291f
C121 xout_xp.G.n0 dout 0.56462f
C122 xout_xp.G.n0 rxn 29.1844f
C123 xout_xp.G.n0 rxp 0.29341f
C124 xout_xp.G.n0 txp 0.23159f
C125 xout_xp.G.n0 txn 0.23264f
C126 xbuf_xp.G.n0 xrc2.P 0.46864f
C127 xbuf_xp.G.n0 VDPWR 6.93788f
C128 xbuf_xp.G.n0 din 0.27764f
C129 xbuf_xp.G.n0 boost 0.21302f
C130 xbuf_xp.G.n0 dout 0.34408f
C131 xbuf_xp.G.n0 rxn 0.29349f
C132 xbuf_xp.G.n0 rxp 0.28919f
C133 xbuf_xp.G.n0 txp 0.23102f
C134 xbuf_xp.G.n0 txn 0.23159f
C135 xrc2.P VDPWR 2.25108f
C136 xrc2.P din 29.3755f
C137 xrc2.P boost 0.1167f
C138 xrc2.P dout 0.36038f
C139 xrc2.P rxn 0.41295f
C140 xrc2.P rxp 0.41287f
C141 xrc2.P txp 1.83748f
C142 xrc2.P txn 2.25339f
C143 VDPWR din 2.41915f
C144 VDPWR boost 3.22302f
C145 VDPWR dout 4.4942f
C146 VDPWR rxn 1.18741f
C147 VDPWR rxp 0.87972f
C148 VDPWR txp 30.1166f
C149 VDPWR txn 1.49021f
C150 din boost 0.22597f
C151 din dout 0.14984f
C152 din rxn 0.20809f
C153 din rxp 0.22623f
C154 din txp 0.10299f
C155 din txn 0.15758f
C156 boost dout 0.1038f
C157 boost rxn 0.15774f
C158 boost rxp 0.15766f
C159 boost txp 0.1017f
C160 boost txn 0.1017f
C161 dout rxn 0.28636f
C162 dout rxp 0.28614f
C163 dout txp 0.22977f
C164 dout txn 0.22977f
C165 rxn rxp 29.0553f
C166 rxn txp 0.10426f
C167 rxn txn 0.10629f
C168 rxp txp 0.10629f
C169 rxp txn 0.11183f
C170 txp txn 29.3266f
C171 txn VGND 3.03765f
C172 txp VGND 3.04219f
C173 rxp VGND 6.48922f
C174 rxn VGND 6.16513f
C175 dout VGND 3.99892f
C176 boost VGND 1.0128f
C177 din VGND 6.56651f
C178 VDPWR VGND 1.468f
C179 xrc2.P VGND 13.5635f
C180 VDPWR.n0 VGND 11.3329f
C181 VDPWR.n1 VGND 6.02078f
C182 VDPWR.t3 VGND 3.45502f
C183 VDPWR.t0 VGND 0.96764f
C184 VDPWR.t12 VGND 1.25305f
C185 VDPWR.t14 VGND 1.25305f
C186 VDPWR.t8 VGND 1.58018f
C187 VDPWR.t6 VGND 1.44976f
C188 VDPWR.n2 VGND 3.00273f
C189 VDPWR.t10 VGND 1.50087f
C190 VDPWR.t2 VGND 1.44976f
C191 VDPWR.n3 VGND 2.07753f
C192 VDPWR.t16 VGND 1.49124f
C193 VDPWR.t4 VGND 1.4847f
C194 VDPWR.n4 VGND 4.81983f
C195 VDPWR.t15 VGND 3.2981f
C196 VDPWR.n5 VGND 16.3085f
C197 VDPWR.t1 VGND 3.35763f
C198 VDPWR.t9 VGND 3.2981f
C199 VDPWR.n6 VGND 11.4214f
C200 VDPWR.t5 VGND 3.35763f
C201 VDPWR.t7 VGND 3.2981f
C202 VDPWR.n7 VGND 12.3535f
C203 VDPWR.t17 VGND 8.44295f
C204 VDPWR.t18 VGND 8.31685f
C205 VDPWR.n8 VGND 11.5867f
C206 VDPWR.t13 VGND 3.37228f
C207 VDPWR.t11 VGND 3.37228f
C208 boost.t0 VGND 0.60101f
C209 boost.t1 VGND 0.3712f
C210 boost.t2 VGND 0.15403f
C211 boost.n0 VGND 8.2592f
C212 boost.t3 VGND 1.60657f
C213 din.t0 VGND 1.31706f
C214 din.t1 VGND 0.74685f
C215 dout.t0 VGND 2.92918f
C216 dout.t1 VGND 2.59658f
C217 rxn.t0 VGND 1.04312f
C218 rxp.t0 VGND 1.05717f
C219 txn.t2 VGND 0.18506f
C220 txn.t1 VGND 0.19269f
C221 txn.t0 VGND 0.07039f
C222 txn.n0 VGND 3.92547f
C223 txp.t2 VGND 0.19995f
C224 txp.t1 VGND 0.19472f
C225 txp.t0 VGND 0.06742f
C226 txp.n0 VGND 3.98655f
C227 xbuf_xp.G.t3 VGND 0.90341f
C228 xbuf_xp.G.t2 VGND 1.50325f
C229 xbuf_xp.G.t1 VGND 0.46841f
C230 xbuf_xp.G.n0 VGND 9.98638f
C231 xbuf_xp.G.t0 VGND 0.90816f
C232 xout_xp.G.t3 VGND 0.94087f
C233 xout_xp.G.t2 VGND 1.5758f
C234 xout_xp.G.t0 VGND 0.45539f
C235 xout_xp.G.n0 VGND 9.78955f
C236 xout_xp.G.t1 VGND 0.88078f
C237 xp2.D.t1 VGND 0.79342f
C238 xp2.D.t3 VGND 1.05877f
C239 xp2.D.t2 VGND 1.80268f
C240 xp2.D.n0 VGND 8.9629f
C241 xp2.D.t0 VGND 1.00363f
C242 xp2.G.t2 VGND 0.64863f
C243 xp2.G.t3 VGND 1.81012f
C244 xp2.G.t1 VGND 1.80835f
C245 xp2.G.n0 VGND 6.47675f
C246 xp2.G.t0 VGND 0.80925f
C247 xrn.P.n0 VGND 8.85134f
C248 xrn.P.n1 VGND 4.76672f
C249 xrn.P.t0 VGND 0.83954f
C250 xrn.P.t6 VGND 0.88882f
C251 xrn.P.t5 VGND 1.44181f
C252 xrn.P.t2 VGND 0.60351f
C253 xrn.P.t3 VGND 0.95439f
C254 xrn.P.t1 VGND 1.06665f
C255 xrn.P.t4 VGND 1.73653f
C256 xrn2.P.t0 VGND 4.91512f
C257 xrn2.P.t1 VGND 8.79856f
C258 xrn2.P.t2 VGND 9.52461f
C259 xrp.P.n0 VGND 8.08631f
C260 xrp.P.t0 VGND 0.75202f
C261 xrp.P.t2 VGND 2.39325f
C262 xrp.P.t3 VGND 2.56612f
C263 xrp.P.t1 VGND 0.86485f
C264 xrp.P.t4 VGND 1.41895f
C265 xrp2.P.t0 VGND 2.65371f
C266 xrp2.P.t1 VGND 4.71641f
C267 xrp2.P.t2 VGND 5.11507f
C268 xrt.P.t0 VGND 3.01737f
C269 xrt.P.t2 VGND 5.95873f
C270 xrt.P.t1 VGND 6.1859f
C271 xtn_xp.G.t3 VGND 0.59952f
C272 xtn_xp.G.t2 VGND 0.5925f
C273 xtn_xp.G.t0 VGND 0.44332f
C274 xtn_xp.G.n0 VGND 8.98714f
C275 xtn_xp.G.t1 VGND 0.80672f
.ends
